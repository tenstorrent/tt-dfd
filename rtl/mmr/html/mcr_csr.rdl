addrmap mcr {
    reg {
        desc = "";
        regwidth = 0x40;
//         constraint_p = "";
        field {
            desc = "Mode selection, 0: DBM off, 1: Normal debug mode, 2: DBM ID output mode, 3: Toggle Mode";
            sw = rw;
            hw = r;
//             reset_port_p = "reset_n_warm_ovrride";
        } Dbmmode[1:0] = 0x0;
        field {
            desc = "Unique DBM ID of the DBM instance";
            sw = rw;
            hw = r;
//             reset_port_p = "reset_n_warm_ovrride";
        } Dbmid[7:2] = 0x0;
        field {
            sw = rw;
            hw = r;
//             reset_port_p = "reset_n_warm_ovrride";
        } Rsvd158[15:8] = 0x0;
        field {
            desc = "Mux Select Bits for Lane 0. Split debug bus into 16 bit segments. Seg0 = debug bus [15:0], Seg1 = debug bus[31:16],.... If all bits are 0, Lane0 = Seg0, if bit[0] = 1, Lane0 = Seg4, if bit[1] =1, Lane0 = Seg5,...";
            sw = rw;
            hw = r;
//             reset_port_p = "reset_n_warm_ovrride";
        } Muxselseg0[21:16] = 0x0;
        field {
            desc = "Mux Select Bits for Lane 1. Split debug bus into 16 bit segments. Seg0 = debug bus [15:0], Seg1 = debug bus[31:16],.... If all bits are 0, Lane1= Seg1, if bit[0] = 1, Lane1 = Seg4, if bit[1] =1, Lane1 = Seg5,...";
            sw = rw;
            hw = r;
//             reset_port_p = "reset_n_warm_ovrride";
        } Muxselseg1[27:22] = 0x0;
        field {
            desc = "Mux Select Bits for Lane 2. Split debug bus into 16 bit segments. Seg0 = debug bus [15:0], Seg1 = debug bus[31:16],.... If all bits are 0, Lane2= Seg2, if bit[0] = 1, Lane2 = Seg4, if bit[1] =1, Lane2 = Seg5,...";
            sw = rw;
            hw = r;
//             reset_port_p = "reset_n_warm_ovrride";
        } Muxselseg2[33:28] = 0x0;
        field {
            desc = "Mux Select Bits for Lane 3. Split debug bus into 16 bit segments. Seg0 = debug bus [15:0], Seg1 = debug bus[31:16],.... If all bits are 0, Lane3= Seg3, if bit[0] = 1, Lane3 = Seg4, if bit[1] =1, Lane3 = Seg5,...";
            sw = rw;
            hw = r;
//             reset_port_p = "reset_n_warm_ovrride";
        } Muxselseg3[39:34] = 0x0;
        field {
            sw = rw;
            hw = r;
//             reset_port_p = "reset_n_warm_ovrride";
        } Muxselseg4[45:40] = 0x0;
        field {
            sw = rw;
            hw = r;
//             reset_port_p = "reset_n_warm_ovrride";
        } Muxselseg5[51:46] = 0x0;
        field {
            sw = rw;
            hw = r;
//             reset_port_p = "reset_n_warm_ovrride";
        } Muxselseg6[57:52] = 0x0;
        field {
            sw = rw;
            hw = r;
//             reset_port_p = "reset_n_warm_ovrride";
        } Muxselseg7[63:58] = 0x0;
    } CDbgMuxSel @ 0x1980;
    reg {
        desc = "";
        regwidth = 0x40;
//         constraint_p = "";
        field {
            sw = rw;
            hw = r;
//             reset_port_p = "reset_n_warm_ovrride";
        } DfdMmrLock[0:0] = 0x1;
        field {
            sw = r;
            hw = r;
//             reset_port_p = "reset_n_warm_ovrride";
        } Rsvd621[62:1] = 0x0;
        field {
            sw = rw;
            hw = r;
//             reset_port_p = "reset_n_warm_ovrride";
        } DfdEn[63:63] = 0x0;
    } CDfdCsr @ 0x1A00;
};

/*
        THIS IS AN AUTOGENERATED ADDRESS MAP

        CDbgMuxSel        @ 0x198
        CDfdCsr           @ 0x1A0
*/

